`include "disciplines.vams"
`include "constants.vams"
// Xyce's K is not the one in constants.vams!
`define X_K (1.3806226e23)

`define attr(txt) (*txt*)

`attr(xyceModelGroup="Resistor", xyceSpiceDeviceName="R", xyceLevelNumber="6")
module resistor (p,n);
   electrical p,n;
   inout p,n;

   `attr(desc="Resistance", type="instance") parameter real R=1 from (0:inf);

   real           Ir;
   real           tdevK;
   real           conductance;

   analog
     begin
        tdevK=$temperature;
        conductance=1.0/R;
        Ir=V(p,n)*conductance;
        I(p,n) <+ Ir;
        I(p,n) <+ white_noise(4*`X_K*tdevK*conductance,"thermal");
     end
endmodule
