//-------------------------------------------------------------------------
//   Copyright 2002-2022 National Technology & Engineering Solutions of
//   Sandia, LLC (NTESS).  Under the terms of Contract DE-NA0003525 with
//   NTESS, the U.S. Government retains certain rights in this software.
//
//   This file is part of the Xyce(TM) Parallel Electrical Simulator.
//
//   Xyce(TM) is free software: you can redistribute it and/or modify
//   it under the terms of the GNU General Public License as published by
//   the Free Software Foundation, either version 3 of the License, or
//   (at your option) any later version.
//
//   Xyce(TM) is distributed in the hope that it will be useful,
//   but WITHOUT ANY WARRANTY; without even the implied warranty of
//   MERCHANTABILITY or FITNESS FOR A PARTICULAR PURPOSE.  See the
//   GNU General Public License for more details.
//
//   You should have received a copy of the GNU General Public License
//   along with Xyce(TM).
//   If not, see <http://www.gnu.org/licenses/>.
//-------------------------------------------------------------------------

//-------------------------------------------------------------------------
//
// Purpose        :
// This example verilog file implements a two-terminal parallel RLC device.
// Its purpose is to demonstrate that Xyce is correctly handling
// branch currents when there are parallel potential and flow contributions
// between the same pair of nodes
//
// Creator        : Tom Russo
//
// Creation Date  : 10/25/2016
//
//-------------------------------------------------------------------------

`include "disciplines.vams"
`include "constants.vams"

`define attr(txt) (*txt*)

module rlc3 (p,n);
   electrical p,n;
   inout p,n;

   `attr(desc="Inductance", type="instance") parameter real L=1e-3 from (0:inf);
   `attr(desc="Resistance", type="instance") parameter real R=1e3 from (0:inf) ;
   `attr(desc="Capacitance", type="instance") parameter real C=1e-12 from (0:inf);

   real           InductorCurrent;
   real           CapacitorCharge;

   branch (p,n) ind_branch;

   analog
     begin

        I(p,n)<+ V(p,n)/R;

        CapacitorCharge = V(p,n)*C;
        I(p,n) <+ ddt(CapacitorCharge);

        InductorCurrent=I(ind_branch);
        V(ind_branch) <+ L*ddt(InductorCurrent);

     end
endmodule
